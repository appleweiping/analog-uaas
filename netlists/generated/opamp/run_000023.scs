simulator lang=spectre
global 0

// ===== user / tech include =====
// include "your_pdk_model.scs"

// ===== parameters injected by python =====
parameters \
  W_IN=1.3757411622150682e-05 \
  L_IN=1.4198854650786426e-06 \
  W_LOAD=3.8586980605760385e-06 \
  L_LOAD=9.565043416740392e-07 \
  W_TAIL=2.8956242078443077e-06 \
  L_TAIL=1.7527328612043762e-06 \
  IBIAS=0.00010054294428457364 \
  CCOMP=1.2594856332745565e-12 \
  W_STAGE2=8.121791144184496e-06 \
  L_STAGE2=3.8386735312601276e-07 \
  VDD=1.8 \
  CLOAD=1e-12 \
  TEMP=27.0

// ===== supplies =====
VDD (vdd 0) vsource dc=VDD
VINP (vinp 0) vsource dc=0.9 ac=0.5
VINN (vinn 0) vsource dc=0.9 ac=-0.5

// ===== placeholder two-stage opamp netlist =====
// 你需要按自己的真实电路替换下面器件定义
// 这里先只保留结构示意，确保模板注入能跑通

I0 (tail 0) isource dc=IBIAS

// input pair
M1 (n1 vinp tail 0) nch w=W_IN l=L_IN
M2 (n2 vinn tail 0) nch w=W_IN l=L_IN

// active load
M3 (n1 n1 vdd vdd) pch w=W_LOAD l=L_LOAD
M4 (n2 n1 vdd vdd) pch w=W_LOAD l=L_LOAD

// second stage
M5 (vout n2 0 0) nch w=W_STAGE2 l=L_STAGE2
M6 (vout vout vdd vdd) pch w=W_LOAD l=L_LOAD

CC (n2 vout) capacitor c=CCOMP
CL (vout 0) capacitor c=CLOAD

// ===== analyses =====
simulatorOptions options temp=TEMP
ac ac start=1 stop=1e9 dec=100
dcOp dc

saveOptions options save=allpub
save v(vout) v(n1) v(n2)

// ===== notes =====
// 真正项目里，建议你通过 OCEAN / calculator 把 gain / gbw / pm / power
// 导出到 run_dir/metrics.txt，格式如下：
// gain_db=63.2
// gbw_hz=1.25e7
// pm_deg=67.8
// power_w=8.5e-4
